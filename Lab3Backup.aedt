# Ansys Electronics Desktop project, version 2022.2
materials:
  PMLGroup1_XYZ_1: permittivity{anisotropic component1=1.6095961 component2=1.6095961 component3=1.6095961} permeability{anisotropic component1=1.6095961 component2=1.6095961 component3=1.6095961} dielectric_loss_tangent{anisotropic component1=1 component2=1 component3=1} magnetic_loss_tangent{anisotropic component1=1 component2=1 component3=1}
  PMLGroup1_XZ_1: permittivity{anisotropic component1=1 component2=0.01 component3=1} permeability{anisotropic component1=1 component2=0.01 component3=1} dielectric_loss_tangent{anisotropic component1=0 component2=518.1599 component3=0} magnetic_loss_tangent{anisotropic component1=0 component2=518.1599 component3=0}
  PMLGroup1_YZ_1: permittivity{anisotropic component1=0.01 component2=1 component3=1} permeability{anisotropic component1=0.01 component2=1 component3=1} dielectric_loss_tangent{anisotropic component1=518.1599 component2=0 component3=0} magnetic_loss_tangent{anisotropic component1=518.1599 component2=0 component3=0}
  PMLGroup1_Z_1: permittivity{anisotropic component1=1.6095961 component2=1.6095961 component3=0.31063694} permeability{anisotropic component1=1.6095961 component2=1.6095961 component3=0.31063694} dielectric_loss_tangent{anisotropic component1=1 component2=1 component3=-1} magnetic_loss_tangent{anisotropic component1=1 component2=1 component3=-1}
  copper: permeability=0.999991 conductivity=58000000
  vacuum: permittivity=1
  PMLGroup1_Z_2: permittivity{anisotropic component1=1.6095961 component2=1.6095961 component3=0.31063694} permeability{anisotropic component1=1.6095961 component2=1.6095961 component3=0.31063694} dielectric_loss_tangent{anisotropic component1=1 component2=1 component3=-1} magnetic_loss_tangent{anisotropic component1=1 component2=1 component3=-1}
  PMLGroup1_XZ_2: permittivity{anisotropic component1=1 component2=0.01 component3=1} permeability{anisotropic component1=1 component2=0.01 component3=1} dielectric_loss_tangent{anisotropic component1=0 component2=518.1599 component3=0} magnetic_loss_tangent{anisotropic component1=0 component2=518.1599 component3=0}
  PMLGroup1_YZ_2: permittivity{anisotropic component1=0.01 component2=1 component3=1} permeability{anisotropic component1=0.01 component2=1 component3=1} dielectric_loss_tangent{anisotropic component1=518.1599 component2=0 component3=0} magnetic_loss_tangent{anisotropic component1=518.1599 component2=0 component3=0}
  PMLGroup1_XYZ_2: permittivity{anisotropic component1=1.6095961 component2=1.6095961 component3=1.6095961} permeability{anisotropic component1=1.6095961 component2=1.6095961 component3=1.6095961} dielectric_loss_tangent{anisotropic component1=1 component2=1 component3=1} magnetic_loss_tangent{anisotropic component1=1 component2=1 component3=1}

design Dipole\_Antenna (HFSS, DrivenModal, model units mm)
variables:
  dipoleL = 51.7mm
  portH = 1mm
  wire = 0.70710678mm
  wireDiameter = 1mm
geometry:
  Cylinder1 [copper] = cylinder(axis=Z, base_centre=(0mm, 0mm, -dipoleL/2), radius=wireDiameter/2, height=dipoleL)
  Cylinder2 = cylinder(axis=Z, base_centre=(0mm, 0mm, -portH/2), radius=wireDiameter/2, height=portH)
  Cylinder1.subtract(Cylinder2)
  Rectangle1 = rectangle(corner=(-wireDiameter/2, 0mm, -portH/2), z_size=portH, x_size=wireDiameter)
  RadiatingSurface [vacuum] = region(absolute_offset=75mm on all sides)
  coordinate_system FaceCS1 = face of RadiatingSurface: Origin=(75.5, -75.5, 100.85) FaceID=RadiatingSurface.face(+z) AxisPosn=(75.5, 75.5, 100.85) WhichAxis=X ZRotationAngle=0deg XOffset=0mm YOffset=0mm
  PML_RadiatingSurface_1 [PMLGroup1_Z_2, oriented by FaceCS1] = sweep_along_normal(RadiatingSurface.face(+z), length=83.339493mm)
  coordinate_system FaceCS2 = face of RadiatingSurface: Origin=(75.5, 75.5, -100.85) FaceID=RadiatingSurface.face(-z) AxisPosn=(75.5, -75.5, -100.85) WhichAxis=X ZRotationAngle=0deg XOffset=0mm YOffset=0mm
  PML_RadiatingSurface_2 [PMLGroup1_Z_2, oriented by FaceCS2] = sweep_along_normal(RadiatingSurface.face(-z), length=83.339493mm)
  coordinate_system FaceCS3 = face of RadiatingSurface: Origin=(-75.5, -75.5, 100.85) FaceID=RadiatingSurface.face(-y) AxisPosn=(-75.5, -75.5, -100.85) WhichAxis=X ZRotationAngle=0deg XOffset=0mm YOffset=0mm
  PML_RadiatingSurface_3 [PMLGroup1_Z_2, oriented by FaceCS3] = sweep_along_normal(RadiatingSurface.face(-y), length=83.339493mm)
  coordinate_system FaceCS4 = face of RadiatingSurface: Origin=(-75.5, 75.5, 100.85) FaceID=RadiatingSurface.face(-x) AxisPosn=(-75.5, 75.5, -100.85) WhichAxis=X ZRotationAngle=0deg XOffset=0mm YOffset=0mm
  PML_RadiatingSurface_4 [PMLGroup1_Z_2, oriented by FaceCS4] = sweep_along_normal(RadiatingSurface.face(-x), length=83.339493mm)
  coordinate_system FaceCS5 = face of RadiatingSurface: Origin=(75.5, 75.5, 100.85) FaceID=RadiatingSurface.face(+y) AxisPosn=(75.5, 75.5, -100.85) WhichAxis=X ZRotationAngle=0deg XOffset=0mm YOffset=0mm
  PML_RadiatingSurface_5 [PMLGroup1_Z_2, oriented by FaceCS5] = sweep_along_normal(RadiatingSurface.face(+y), length=83.339493mm)
  coordinate_system FaceCS6 = face of RadiatingSurface: Origin=(75.5, -75.5, 100.85) FaceID=RadiatingSurface.face(+x) AxisPosn=(75.5, -75.5, -100.85) WhichAxis=X ZRotationAngle=0deg XOffset=0mm YOffset=0mm
  PML_RadiatingSurface_6 [PMLGroup1_Z_2, oriented by FaceCS6] = sweep_along_normal(RadiatingSurface.face(+x), length=83.339493mm)
  PML_RadiatingSurface_7 [PMLGroup1_XZ_2, oriented by FaceCS3] = sweep_along_normal(PML_RadiatingSurface_1.face(at (0, -75.5, 142.52)), length=83.339493mm)
  PML_RadiatingSurface_8 [PMLGroup1_XZ_2, oriented by FaceCS4] = sweep_along_normal(PML_RadiatingSurface_1.face(at (-75.5, 0, 142.52)), length=83.339493mm)
  PML_RadiatingSurface_9 [PMLGroup1_XZ_2, oriented by FaceCS5] = sweep_along_normal(PML_RadiatingSurface_1.face(at (0, 75.5, 142.52)), length=83.339493mm)
  PML_RadiatingSurface_10 [PMLGroup1_YZ_2, oriented by FaceCS1] = sweep_along_normal(PML_RadiatingSurface_1.face(at (75.5, 0, 142.52)), length=83.339493mm)
  coordinate_system FaceCS7 = face of RadiatingSurface: Origin=(75.5, -75.5, -100.85) FaceID=RadiatingSurface.face(-z) AxisPosn=(-75.5, -75.5, -100.85) WhichAxis=X ZRotationAngle=0deg XOffset=0mm YOffset=0mm
  PML_RadiatingSurface_11 [PMLGroup1_YZ_2, oriented by FaceCS7] = sweep_along_normal(PML_RadiatingSurface_2.face(at (0, -75.5, -142.52)), length=83.339493mm)
  coordinate_system FaceCS8 = face of RadiatingSurface: Origin=(-75.5, -75.5, -100.85) FaceID=RadiatingSurface.face(-z) AxisPosn=(-75.5, 75.5, -100.85) WhichAxis=X ZRotationAngle=0deg XOffset=0mm YOffset=0mm
  PML_RadiatingSurface_12 [PMLGroup1_YZ_2, oriented by FaceCS8] = sweep_along_normal(PML_RadiatingSurface_2.face(at (-75.5, 0, -142.52)), length=83.339493mm)
  PML_RadiatingSurface_13 [PMLGroup1_XZ_2, oriented by FaceCS2] = sweep_along_normal(PML_RadiatingSurface_2.face(at (0, 75.5, -142.52)), length=83.339493mm)
  PML_RadiatingSurface_14 [PMLGroup1_YZ_2, oriented by FaceCS2] = sweep_along_normal(PML_RadiatingSurface_2.face(at (75.5, 0, -142.52)), length=83.339493mm)
  PML_RadiatingSurface_15 [PMLGroup1_YZ_2, oriented by FaceCS3] = sweep_along_normal(PML_RadiatingSurface_3.face(at (-75.5, -117.17, 0)), length=83.339493mm)
  PML_RadiatingSurface_16 [PMLGroup1_YZ_2, oriented by FaceCS6] = sweep_along_normal(PML_RadiatingSurface_3.face(at (75.5, -117.17, 0)), length=83.339493mm)
  PML_RadiatingSurface_17 [PMLGroup1_YZ_2, oriented by FaceCS4] = sweep_along_normal(PML_RadiatingSurface_4.face(at (-117.17, 75.5, 0)), length=83.339493mm)
  PML_RadiatingSurface_18 [PMLGroup1_YZ_2, oriented by FaceCS5] = sweep_along_normal(PML_RadiatingSurface_5.face(at (75.5, 117.17, 0)), length=83.339493mm)
  PML_RadiatingSurface_19 [PMLGroup1_XYZ_2, oriented by FaceCS3] = sweep_along_normal(PML_RadiatingSurface_7.face(at (-75.5, -117.17, 142.52)), length=83.339493mm)
  PML_RadiatingSurface_20 [PMLGroup1_XYZ_2, oriented by FaceCS1] = sweep_along_normal(PML_RadiatingSurface_7.face(at (75.5, -117.17, 142.52)), length=83.339493mm)
  PML_RadiatingSurface_21 [PMLGroup1_XYZ_2, oriented by FaceCS4] = sweep_along_normal(PML_RadiatingSurface_8.face(at (-117.17, 75.5, 142.52)), length=83.339493mm)
  PML_RadiatingSurface_22 [PMLGroup1_XYZ_2, oriented by FaceCS5] = sweep_along_normal(PML_RadiatingSurface_9.face(at (75.5, 117.17, 142.52)), length=83.339493mm)
  PML_RadiatingSurface_23 [PMLGroup1_XYZ_2, oriented by FaceCS8] = sweep_along_normal(PML_RadiatingSurface_11.face(at (-75.5, -117.17, -142.52)), length=83.339493mm)
  PML_RadiatingSurface_24 [PMLGroup1_XYZ_2, oriented by FaceCS7] = sweep_along_normal(PML_RadiatingSurface_11.face(at (75.5, -117.17, -142.52)), length=83.339493mm)
  coordinate_system FaceCS9 = face of RadiatingSurface: Origin=(-75.5, 75.5, -100.85) FaceID=RadiatingSurface.face(-z) AxisPosn=(75.5, 75.5, -100.85) WhichAxis=X ZRotationAngle=0deg XOffset=0mm YOffset=0mm
  PML_RadiatingSurface_25 [PMLGroup1_XYZ_2, oriented by FaceCS9] = sweep_along_normal(PML_RadiatingSurface_12.face(at (-117.17, 75.5, -142.52)), length=83.339493mm)
  PML_RadiatingSurface_26 [PMLGroup1_XYZ_2, oriented by FaceCS2] = sweep_along_normal(PML_RadiatingSurface_13.face(at (75.5, 117.17, -142.52)), length=83.339493mm)
  group PMLGroup1 = PML_RadiatingSurface_1..PML_RadiatingSurface_26
boundaries and excitations:
  PML_radiation1: Radiation Faces=RadiatingSurface.face(+z) IsForPML
  PML_radiation2: Radiation Faces=RadiatingSurface.face(-z) IsForPML
  PML_radiation3: Radiation Faces=RadiatingSurface.face(-y) IsForPML
  PML_radiation4: Radiation Faces=RadiatingSurface.face(-x) IsForPML
  PML_radiation5: Radiation Faces=RadiatingSurface.face(+y) IsForPML
  PML_radiation6: Radiation Faces=RadiatingSurface.face(+x) IsForPML
  1: Lumped Port Objects=Rectangle1 Modes{Mode1{IntLine{(0, 0, 0.5) -> (0, 0, -0.5)} CharImp=Zpi RenormImp=50ohm}} Impedance=50ohm
setups:
  Setup1: HfssDriven Frequency=2.9GHz MaxDeltaS=0.01 MaximumPasses=15 MinimumPasses=6 MinimumConvergedPasses=3 PercentRefinement=30 BasisOrder=1 PortAccuracy=2 DrivenSolverType="Direct Solver"
    sweep Sweep: 1GHz to 3GHz, 401 points; Type=Interpolating InterpTolerance=0.5 InterpMaxSolns=250 InterpUsePortImped=false PassivityErrorTolerance=0.0001
source amplitudes:
  1:1: 1W 0deg
radiation setups:
  Infinite Sphere1: Infinite Sphere Theta=-180deg..180deg step 1deg Phi=0deg..360deg step 1deg
